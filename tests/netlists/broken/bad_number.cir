Bad number
V1 in 0 DC 5
R1 in out 4.7.2k
R2 out 0 2k
.op
.end

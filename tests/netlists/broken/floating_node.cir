Floating node
V1 in 0 DC 5
R1 in out 1k
R2 out 0 2k
R3 out nc 1k     ; nc is not connected to anything else
.op
.end

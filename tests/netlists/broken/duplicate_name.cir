Duplicate element name
V1 in 0 DC 5
R1 in out 1k
R1 out 0 2k
.op
.end

Inverting amplifier with a behavioural op-amp subcircuit
.subckt opamp inp inn out
Rin inp inn 1meg
E1 int 0 inp inn 1e5
Rout int out 75
.ends opamp
V1 in 0 DC 0 AC 1 SIN(0 0.1 1k)
R1 in inv 10k
R2 inv out 100k
X1 0 inv out opamp
RL out 0 10k
.tran 10u 5m
.end

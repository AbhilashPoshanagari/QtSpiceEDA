RC low-pass filter, fc = 1.59 kHz
* Pulse and AC source driving a first-order RC filter.
V1 in 0 DC 0 AC 1 PULSE(0 1 0 1n 1n 0.5m 1m)
R1 in out 1k      ; series resistor
C1 out 0 100n
.ac dec 20 1 1meg
.tran 10u 5m
.end
